ADE simulation setup
Run mode: Single Run, Sweeps and Corners
Tests:
  prc:CML_tb:1: DEMO_AMP_CS/AMP_CS_tb_dc/config, simulator spectre
    Outputs: vout; eye_out; eye_maxHeight; eye_maxWidth; gain; gain_dB; DC_Gain; GBW; BW; vin; om; V2; AV; V1
Global variables:
  VCC = 0.8 (off)
  CL = 30f
  Rin = 1500
  Vin = 300m
  BW = 30G
  gain_fb = 2.000000e+02
  vimax = 1.000000e+00
  vimin = 0.000000e+00
  vbias = 1.850000e-01
  vdd = 1.000000e+00
  voutref = 5.000000e-01
  vout_start = 1.000000e-01
  vout_stop = 9.000000e-01
  vout_num = 1.000000e+02
Corners (nominal off):
  model folders: /nfs/ug/groups/lipixgrp/BAG2_cds_ff_mpt_N65/cds_ff_mpt/workspace_setup/models/spectre
  tt: temperature=25; crn65gplus_2d5_lk_v1d0.scs[tt_lvt]
  tt_lvt (off): temperature=25; crn65gplus_2d5_lk_v1d0.scs[tt_lvt]
  ss (off): temperature=25; crn65gplus_2d5_lk_v1d0.scs[ss]
