ADE simulation setup
Run mode: Single Run, Sweeps and Corners
Tests:
  tb_ac_tran: DEMO_AMP_CS/AMP_CS_tb_ac_tran/config, simulator spectre
Global variables:
  ibias = 100u
  vdd = 1.000000e+00
  vinac = 1.000000e+00
  vindc = 5.600000e-01
  fstart = 1.000000e+06
  fstop = 1.000000e+11
  fndec = 2.000000e+01
  tsim = 2.000000e-09
  tstep = 1.000000e-12
  cload = 4.000000e-14
  vbias = 1.850000e-01
Corners (nominal off):
  model folders: /groups/haczgrp/Hubert/BAG2_cds_ff_mpt_N65/cds_ff_mpt/workspace_setup/models/spectre, /nfs/ug/groups/haczgrp/Hubert/BAG2_cds_ff_mpt_N65/cds_ff_mpt/workspace_setup/models/spectre
  tt_1 (off): temperature=25; crn65gplus_2d5_lk_v1d0.scs[tt]
  tt: temperature=25; crn65gplus_2d5_lk_v1d0.scs[ff]
  ss (off): temperature=25; crn65gplus_2d5_lk_v1d0.scs
