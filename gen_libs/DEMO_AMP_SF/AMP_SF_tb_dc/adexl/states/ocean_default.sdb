ADE simulation setup
Run mode: Single Run, Sweeps and Corners
Tests:
  tb_dc: DEMO_AMP_SF/AMP_SF_tb_dc/config, simulator spectre
Global variables:
  gain_fb = -2.000000e+02
  ibias = 100u
  vdd = 1.000000e+00
  vout_start = 1.500000e-01
  vout_stop = 5.000000e-01
  vout_num = 1.000000e+02
  voutref = 5.000000e-01
  vimax = 1.000000e+00
  vimin = 0.000000e+00
  vbias = 5.400000e-01
Corners (nominal off):
  model folders: /CMC/kits/tsmc_65nm/CRN65GP-OA/PDK_OA/models/spectre
  tt: temperature=25; crn65gplus_2d5_lk_v1d0.scs[tt]
  ff (off): temperature=25; crn65gplus_2d5_lk_v1d0.scs[ff]
  ss (off): temperature=25; crn65gplus_2d5_lk_v1d0.scs[ss]
  sf (off): temperature=25; crn65gplus_2d5_lk_v1d0.scs[sf]
  fs (off): temperature=25; crn65gplus_2d5_lk_v1d0.scs[fs]
  ff_hot (off): temperature=65; crn65gplus_2d5_lk_v1d0.scs[ff]
  ss_hot (off): temperature=65; crn65gplus_2d5_lk_v1d0.scs[ss]
  ss_cold (off): temperature=0; crn65gplus_2d5_lk_v1d0.scs[ss]
