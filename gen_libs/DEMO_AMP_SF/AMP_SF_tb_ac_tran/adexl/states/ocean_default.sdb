ADE simulation setup
Run mode: Single Run, Sweeps and Corners
Tests:
  tb_ac_tran: DEMO_AMP_SF/AMP_SF_tb_ac_tran/config, simulator spectre
Global variables:
  ibias = 100u
  vdd = 1.000000e+00
  vinac = 1.000000e+00
  vindc = 7.000000e-01
  fstart = 1.000000e+06
  fstop = 1.000000e+11
  fndec = 2.000000e+01
  tsim = 2.000000e-09
  tstep = 1.000000e-12
  cload = 4.000000e-14
  vbias = 5.400000e-01
Corners (nominal off):
  model folders: /CMC/kits/tsmc_65nm/CRN65GP-OA/PDK_OA/models/spectre
  tt: temperature=25; crn65gplus_2d5_lk_v1d0.scs[tt]
  ff (off): temperature=25; crn65gplus_2d5_lk_v1d0.scs[ff]
  ss (off): temperature=25; crn65gplus_2d5_lk_v1d0.scs[ss]
  sf (off): temperature=25; crn65gplus_2d5_lk_v1d0.scs[sf]
  fs (off): temperature=25; crn65gplus_2d5_lk_v1d0.scs[fs]
  ff_hot (off): temperature=65; crn65gplus_2d5_lk_v1d0.scs[ff]
  ss_hot (off): temperature=65; crn65gplus_2d5_lk_v1d0.scs[ss]
  ss_cold (off): temperature=0; crn65gplus_2d5_lk_v1d0.scs[ss]
