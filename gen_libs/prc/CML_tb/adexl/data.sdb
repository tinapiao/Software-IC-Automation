ADE simulation setup
Run mode: Single Run, Sweeps and Corners
Tests:
  prc:CML_tb:1: prc/CML_tb/schematic, simulator spectre
    Outputs: out; eye_out; eye_maxHeight; eye_maxWidth; gain; gain_dB; DC_Gain; GBW; BW; in
Global variables:
  VCC = 0.8
