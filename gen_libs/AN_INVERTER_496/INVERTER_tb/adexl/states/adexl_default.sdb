ADE simulation setup
Run mode: Single Run, Sweeps and Corners
Tests:
  AN_INVERTER_496:INVERTER_tb:1: AN_INVERTER_496/INVERTER_tb/config, simulator spectre
    Outputs: RiseTime; gain; ymax(clip(VT("/vout") 1e+10 8e+10)); Vout_Swing_PP; FallTime
Global variables:
  BW = 1.000000e+10
  CL = 2.000000e-13
  Vin = 1.000000e+00
  Rin = 8.000000e+02
  Cin = 5.000000e-15
  vtest = 1
Corners (nominal off):
  model folders: /nfs/ug/groups/lipixgrp/BAG2_cds_ff_mpt_N65/cds_ff_mpt/workspace_setup/models/spectre
  tt: temperature=25; crn65gplus_2d5_lk_v1d0.scs[tt_lvt]
  tt_lvt (off): temperature=25; crn65gplus_2d5_lk_v1d0.scs[tt_lvt]
  ss (off): temperature=25; crn65gplus_2d5_lk_v1d0.scs[ss]
